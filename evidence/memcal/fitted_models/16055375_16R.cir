* Owner-measured matrix fit; values are kOhm.
* Candidate DC resistor model; no undocumented device dynamics.
.subckt NETRES_16055375_16R P1 P2 P3 P4 P5 P6 P7 P8 P9 P10 P11 P12 P13 P14
R1 P1 P2 12.7k
R2 P1 P12 1870k
R3 P1 P14 71.5k
R4 P2 P3 34.8k
R5 P3 P4 1500k
R6 P3 P14 14.3k
R7 P4 P5 31.6k
R8 P5 P6 45.3k
R9 P5 P14 178k
R10 P6 P9 267k
R11 P7 P9 71.5k
R12 P9 P14 412k
R13 P10 P14 88.7k
R14 P11 P14 95.3k
R15 P12 P14 9.76k
R16 P13 P14 16.9k
VSHORT1 P7 P8 0
.ends NETRES_16055375_16R
