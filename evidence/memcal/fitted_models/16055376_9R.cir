* Owner-measured matrix fit; values are kOhm.
* Candidate DC resistor model; no undocumented device dynamics.
.subckt NETRES_16055376_9R P1 P2 P3 P4 P5 P6 P7 P8 P9 P10 P11 P12 P13 P14 P15 P16
R1 P1 P2 150k
R2 P1 P16 10k
R3 P2 P3 1.4k
R4 P3 P4 130k
R5 P3 P13 7.5k
R6 P3 P14 4.99k
R7 P3 P15 8.25k
R8 P4 P6 24.9k
R9 P11 P12 10k
VSHORT1 P4 P5 0
VSHORT2 P7 P9 0
.ends NETRES_16055376_9R
